* SPICE3 file created from inv.ext - technology: sky130A

.option scale=10m
